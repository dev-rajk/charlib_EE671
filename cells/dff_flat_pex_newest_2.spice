* NGSPICE file created from dff_flat.ext - technology: sky130A

.subckt dff_flat D CLK Q VDD VSS
X0 a_2981_68# a_1741_53# VDD VDD sky130_fd_pr__pfet_01v8 ad=0.235 pd=1.96667 as=0.3525 ps=2.95 w=1.175 l=0.15
**devattr s=14100,590 d=7050,295
X1 a_4352_53# a_290_67# a_2981_68# VDD sky130_fd_pr__pfet_01v8 ad=0.3525 pd=2.95 as=0.235 ps=1.96667 w=1.175 l=0.15
**devattr s=14100,590 d=14100,590
X2 a_4352_53# a_290_67# a_4262_53# VSS sky130_fd_pr__nfet_01v8 ad=0.126 pd=1.44 as=0.126 ps=1.44 w=0.42 l=0.15
**devattr s=5040,288 d=5040,288
X3 Q a_5592_68# VSS VSS sky130_fd_pr__nfet_01v8 ad=0.126 pd=1.44 as=0.126 ps=1.44 w=0.42 l=0.15
**devattr s=5040,288 d=5040,288
X4 a_989_66# D VSS VSS sky130_fd_pr__nfet_01v8 ad=0.084 pd=0.96 as=0.126 ps=1.44 w=0.42 l=0.15
**devattr s=5040,288 d=2520,144
X5 a_2981_68# a_1741_53# VSS VSS sky130_fd_pr__nfet_01v8 ad=0.084 pd=0.96 as=0.126 ps=1.44 w=0.42 l=0.15
**devattr s=5040,288 d=2520,144
X6 a_1741_53# CLK a_989_66# VDD sky130_fd_pr__pfet_01v8 ad=0.3525 pd=2.95 as=0.235 ps=1.96667 w=1.175 l=0.15
**devattr s=14100,590 d=14100,590
X7 a_4352_53# CLK a_2981_68# VSS sky130_fd_pr__nfet_01v8 ad=0.126 pd=1.44 as=0.084 ps=0.96 w=0.42 l=0.15
**devattr s=5040,288 d=5040,288
X8 a_1741_53# a_290_67# a_989_66# VSS sky130_fd_pr__nfet_01v8 ad=0.126 pd=1.44 as=0.084 ps=0.96 w=0.42 l=0.15
**devattr s=5040,288 d=5040,288
X9 VSS CLK a_290_67# VSS sky130_fd_pr__nfet_01v8 ad=0.126 pd=1.44 as=0.063 ps=0.72 w=0.42 l=0.15
**devattr s=2520,144 d=5040,288
X10 a_1651_53# a_2981_68# VDD VDD sky130_fd_pr__pfet_01v8 ad=0.3525 pd=2.95 as=0.3525 ps=2.95 w=1.175 l=0.15
**devattr s=14100,590 d=14100,590
X11 a_4352_53# CLK a_4262_53# VDD sky130_fd_pr__pfet_01v8 ad=0.3525 pd=2.95 as=0.3525 ps=2.95 w=1.175 l=0.15
**devattr s=14100,590 d=14100,590
X12 VDD a_4352_53# a_5592_68# VDD sky130_fd_pr__pfet_01v8 ad=0.3525 pd=2.95 as=0.17625 ps=1.475 w=1.175 l=0.15
**devattr s=7050,295 d=14100,590
X13 a_5592_68# a_4352_53# VSS VSS sky130_fd_pr__nfet_01v8 ad=0.063 pd=0.72 as=0.126 ps=1.44 w=0.42 l=0.15
**devattr s=5040,288 d=2520,144
X14 a_5592_68# a_4352_53# VDD VDD sky130_fd_pr__pfet_01v8 ad=0.17625 pd=1.475 as=0.3525 ps=2.95 w=1.175 l=0.15
**devattr s=14100,590 d=7050,295
X15 VDD CLK a_290_67# VDD sky130_fd_pr__pfet_01v8 ad=0.3525 pd=2.95 as=0.17625 ps=1.475 w=1.175 l=0.15
**devattr s=7050,295 d=14100,590
X16 a_290_67# CLK VDD VDD sky130_fd_pr__pfet_01v8 ad=0.17625 pd=1.475 as=0.3525 ps=2.95 w=1.175 l=0.15
**devattr s=14100,590 d=7050,295
X17 VSS D a_989_66# VSS sky130_fd_pr__nfet_01v8 ad=0.126 pd=1.44 as=0.084 ps=0.96 w=0.42 l=0.15
**devattr s=2520,144 d=5040,288
X18 a_4262_53# a_5592_68# VDD VDD sky130_fd_pr__pfet_01v8 ad=0.3525 pd=2.95 as=0.3525 ps=2.95 w=1.175 l=0.15
**devattr s=14100,590 d=14100,590
X19 a_1651_53# a_2981_68# VSS VSS sky130_fd_pr__nfet_01v8 ad=0.126 pd=1.44 as=0.126 ps=1.44 w=0.42 l=0.15
**devattr s=5040,288 d=5040,288
X20 a_290_67# CLK VSS VSS sky130_fd_pr__nfet_01v8 ad=0.063 pd=0.72 as=0.126 ps=1.44 w=0.42 l=0.15
**devattr s=5040,288 d=2520,144
X21 VDD a_1741_53# a_2981_68# VDD sky130_fd_pr__pfet_01v8 ad=0.3525 pd=2.95 as=0.235 ps=1.96667 w=1.175 l=0.15
**devattr s=7050,295 d=14100,590
X22 Q a_5592_68# VDD VDD sky130_fd_pr__pfet_01v8 ad=0.3525 pd=2.95 as=0.3525 ps=2.95 w=1.175 l=0.15
**devattr s=14100,590 d=14100,590
X23 a_1741_53# CLK a_1651_53# VSS sky130_fd_pr__nfet_01v8 ad=0.126 pd=1.44 as=0.126 ps=1.44 w=0.42 l=0.15
**devattr s=5040,288 d=5040,288
X24 a_989_66# D VDD VDD sky130_fd_pr__pfet_01v8 ad=0.235 pd=1.96667 as=0.3525 ps=2.95 w=1.175 l=0.15
**devattr s=14100,590 d=7050,295
X25 a_1741_53# a_290_67# a_1651_53# VDD sky130_fd_pr__pfet_01v8 ad=0.3525 pd=2.95 as=0.3525 ps=2.95 w=1.175 l=0.15
**devattr s=14100,590 d=14100,590
X26 VSS a_1741_53# a_2981_68# VSS sky130_fd_pr__nfet_01v8 ad=0.126 pd=1.44 as=0.084 ps=0.96 w=0.42 l=0.15
**devattr s=2520,144 d=5040,288
X27 VSS a_4352_53# a_5592_68# VSS sky130_fd_pr__nfet_01v8 ad=0.126 pd=1.44 as=0.063 ps=0.72 w=0.42 l=0.15
**devattr s=2520,144 d=5040,288
X28 VDD D a_989_66# VDD sky130_fd_pr__pfet_01v8 ad=0.3525 pd=2.95 as=0.235 ps=1.96667 w=1.175 l=0.15
**devattr s=7050,295 d=14100,590
X29 a_4262_53# a_5592_68# VSS VSS sky130_fd_pr__nfet_01v8 ad=0.126 pd=1.44 as=0.126 ps=1.44 w=0.42 l=0.15
**devattr s=5040,288 d=5040,288
C0 a_5592_68# a_4262_53# 0.39904f
C1 a_989_66# a_290_67# 0.40724f
C2 a_4352_53# a_4262_53# 0.46608f
C3 a_4262_53# a_1741_53# 0
C4 a_5592_68# VDD 0.7338f
C5 a_4352_53# VDD 0.23267f
C6 VDD a_1741_53# 0.21191f
C7 D VDD 0.13836f
C8 a_1651_53# a_290_67# 1.35081f
C9 CLK a_4262_53# 0.21085f
C10 a_2981_68# a_290_67# 0.37803f
C11 Q a_4262_53# 0
C12 CLK VDD 2.29131f
C13 Q VDD 0.11597f
C14 a_5592_68# a_290_67# 0
C15 a_989_66# a_1651_53# 0.05837f
C16 a_4352_53# a_290_67# 0.06281f
C17 a_290_67# a_1741_53# 0.36031f
C18 D a_290_67# 0.02944f
C19 a_2981_68# a_989_66# 0.01937f
C20 CLK a_290_67# 1.92871f
C21 a_2981_68# a_1651_53# 0.18146f
C22 a_989_66# a_1741_53# 0.37469f
C23 a_989_66# D 0.08013f
C24 CLK a_989_66# 0.34988f
C25 a_4352_53# a_1651_53# 0
C26 a_2981_68# a_5592_68# 0.00418f
C27 a_1651_53# a_1741_53# 0.43899f
C28 D a_1651_53# 0
C29 a_4352_53# a_2981_68# 0.37641f
C30 a_2981_68# a_1741_53# 0.10822f
C31 CLK a_1651_53# 0.09062f
C32 CLK a_2981_68# 0.33924f
C33 a_4352_53# a_5592_68# 0.09761f
C34 a_4352_53# a_1741_53# 0
C35 D a_1741_53# 0.00167f
C36 CLK a_5592_68# 0
C37 CLK a_4352_53# 0.2351f
C38 CLK a_1741_53# 0.10711f
C39 Q a_5592_68# 0.03729f
C40 CLK D 0.07523f
C41 Q a_4352_53# 0
C42 VDD a_4262_53# 0.50051f
C43 a_4262_53# a_290_67# 0.06597f
C44 VDD a_290_67# 1.53253f
C45 a_989_66# VDD 0.45501f
C46 a_1651_53# a_4262_53# 0.00898f
C47 a_2981_68# a_4262_53# 0.08838f
C48 a_1651_53# VDD 0.25532f
C49 a_2981_68# VDD 0.59853f
C50 Q VSS 0.70632f
C51 VDD VSS 10.35253f
C52 a_4262_53# VSS 1.47897f
C53 a_2981_68# VSS 0.64514f
C54 a_1651_53# VSS 2.37598f
C55 a_989_66# VSS 2.18826f
.ends
